ADE simulation setup
Run mode: Single Run, Sweeps and Corners
Tests:
  dac_dac_1: dac/dac/schematic, simulator spectre
    Variables: R = 1k
    Outputs: VT; /OUT; /data_out<0:63>
