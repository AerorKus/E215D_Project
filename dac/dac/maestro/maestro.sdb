ADE simulation setup
Run mode: Single Run, Sweeps and Corners
Tests:
  dac_dac_1: dac/dac/schematic, simulator spectre
    Variables: R = 1k; fin = 10k; VDD = 1.8; VREF = 1.8
    Outputs: VT; /OUT; /data_out<0:63>; /VADC; /VADC<9:0>; /net28; /net30
