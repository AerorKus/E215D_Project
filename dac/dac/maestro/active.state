ADE simulation setup
Test dac_dac_1: dac/dac/schematic, simulator spectre
  Models: /w/class.1/ee/ee215d/ee215dt2/DesignKits/TSMC180PDK/PDK/tsmc18/../models/spectre/cr018gpii_v1d0.scs[tt_rfres_sa, tt_rfmvar, tt_rtmom, tt_disres, tt, tt_rfesd, tt_mim, tt_fmom, tt_rfres_rpo, tt_m, tt_rfmim, tt_res, tt_bip, tt_bip3, tt_dio3, tt_3v, tt_na, tt_dio, tt_dio_m, tt_rfind, tt_dio_3m, tt_bbmvar, tt_rfres_hri, tt_3vna, tt_dio_dnw, tt_3m, tt_rfjvar, tt_rfmos, tt_rfsbd, tt_rfmvar_33, tt_rfmos33, tt_rffmom, stat_noise]
  Variables: VREF = 1.8; R = 1k; fin = 10k; VDD = 1.8
  Temperature: 27
  Analysis tran: stop=100u errpreset=conservative strobeperiod=1n
  Analysis dc: (saves the operating point)
  Signals: /OUT, /data_out<0:63>, /net28, /VADC<9:0>, /net30
Run mode: Single Run, Sweeps and Corners
