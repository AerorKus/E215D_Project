ADE simulation setup
Test dac_dac_1: dac/dac/schematic, simulator spectre
  Models: /w/class.1/ee/ee215d/ee215dt2/DesignKits/TSMC180PDK/PDK/tsmc18/../models/spectre/cr018gpii_v1d0.scs[tt_rfres_sa, tt_rfmvar, tt_rtmom, tt_disres, tt, tt_rfesd, tt_mim, tt_fmom, tt_rfres_rpo, tt_m, tt_rfmim, tt_res, tt_bip, tt_bip3, tt_dio3, tt_3v, tt_na, tt_dio, tt_dio_m, tt_rfind, tt_dio_3m, tt_bbmvar, tt_rfres_hri, tt_3vna, tt_dio_dnw, tt_3m, tt_rfjvar, tt_rfmos, tt_rfsbd, tt_rfmvar_33, tt_rfmos33, tt_rffmom, stat_noise]
  Variables: R = 1k
  Temperature: 27
  Stimulus data_in<0>: voltage dc dc=0 srcType=dc
  Stimulus data_in<1>: voltage dc dc=1.25 srcType=dc
  Stimulus data_in<2>: voltage dc dc=1.25 srcType=dc
  Stimulus data_in<3>: voltage dc dc=1.25 srcType=dc
  Stimulus data_in<4>: voltage dc dc=1.25 srcType=dc
  Stimulus data_in<5>: voltage dc dc=1.25 srcType=dc
  Analysis tran: stop=1u errpreset=conservative
  Analysis dc: (saves the operating point)
  Signals: /OUT, /data_out<0:63>
Run mode: Single Run, Sweeps and Corners
