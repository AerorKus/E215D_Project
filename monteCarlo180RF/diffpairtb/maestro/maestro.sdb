ADE simulation setup
Run mode: Monte Carlo Sampling
Tests:
  monteCarlo180RF_diffpairtb_1: monteCarlo180RF/diffpairtb/schematic, simulator spectre
    Variables: VDD = 1.8; corner = "tt"
    Outputs: Av; Vos,in
Corners:
  SS: corner="ss"
  SF: corner="sf"
  TT: corner="tt"
  FS: corner="fs"
  FF: corner="ff"
Monte Carlo Sampling options: ignoremode=default, mismatchvary=Gaussian, sssnumpoints=7000, mismatchscale=1.0, processscale=1.0, pointsPerJobPolicy=Group automatically, maxPointsPerJob=10, reliabilitymode=singlestress, wcdinitialpoints=200, mcnumpoints=500, yeyistostart=3.0, mcSigmaTarget=3, yeiterations=10, processvary=Gaussian, yeexpectedyield=3, mcmethod=mismatch, yeusehistorymc=0, yeuseautomcsamples=1, yecreatecorners=0, mcdistandscalingmismatchenable=0, parasiticanalysis=0, mcFilterPluginEnabled=0, haveyeyieldtostart=1, yeusevarreduction=1, mcdistandscalingprocessenable=0
