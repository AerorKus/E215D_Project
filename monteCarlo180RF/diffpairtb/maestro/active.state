ADE simulation setup
Test monteCarlo180RF_diffpairtb_1: monteCarlo180RF/diffpairtb/schematic, simulator spectre
  Models: /w/class.1/ee/ee215d/ee215dt2/DesignKits/TSMC180PDK/PDK/tsmc18/../models/spectre/cr018gpii_v1d0.scs[tt_rfres_sa, tt_rfmvar, tt_rtmom, tt_disres, VAR(\, tt_rfesd, tt_mim, tt_fmom, tt_rfres_rpo, tt_m, tt_rfmim, tt_res, tt_bip, tt_bip3, tt_dio3, tt_3v, tt_na, tt_dio, tt_dio_m, tt_rfind, tt_dio_3m, tt_bbmvar, tt_rfres_hri, tt_3vna, tt_dio_dnw, tt_3m, tt_rfjvar, tt_rfmos, tt_rfsbd, tt_rfmvar_33, tt_rfmos33, tt_rffmom, stat_noise, stat, stat_mis]
  Variables: VDD = 1.8; corner = "\"tt\""
  Temperature: 27
  Analysis dc: (saves the operating point)
  Analysis ac: start=1M stop=1G dec=50
  Output Av = value(dB10((vfreq("ac" "/VON") * vfreq("ac" "/VOP"))) 1000000)
  Output Vos,in = ((VDC("/VOP") - VDC("/VON")) / Av)
  Signals: /VOP, /VON
Run mode: Monte Carlo Sampling
Corners:
  SS: corner="ss"
  SF: corner="sf"
  TT: corner="tt"
  FS: corner="fs"
  FF: corner="ff"
Monte Carlo Sampling options: ignoremode=default, mismatchvary=Gaussian, sssnumpoints=7000, mismatchscale=1.0, processscale=1.0, pointsPerJobPolicy=Group automatically, maxPointsPerJob=10, reliabilitymode=singlestress, wcdinitialpoints=200, mcnumpoints=500, yeyistostart=3.0, mcSigmaTarget=3, yeiterations=10, processvary=Gaussian, yeexpectedyield=3, mcmethod=mismatch, yeusehistorymc=0, yeuseautomcsamples=1, yecreatecorners=0, mcdistandscalingmismatchenable=0, parasiticanalysis=0, mcFilterPluginEnabled=0, haveyeyieldtostart=1, yeusevarreduction=1, mcdistandscalingprocessenable=0
Setup values for test monteCarlo180RF_diffpairtb_1: corner = "tt"
